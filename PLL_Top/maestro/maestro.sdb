ADE simulation setup
Run mode: Single Run, Sweeps and Corners
Tests:
  EECS251B_project_CP_PLL_PLL_Top_1: EECS251B_project_CP_PLL/PLL_Top/schematic, simulator spectre
    Variables: f_clk = 50MHz; t_delay = 0; t_rise = 1p
    Outputs: VT("/Vout"); VT("/CLK_FB"); VT("/CLK_IN")
