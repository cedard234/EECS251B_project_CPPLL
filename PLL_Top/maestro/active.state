ADE simulation setup
Test EECS251B_project_CP_PLL_PLL_Top_1: EECS251B_project_CP_PLL/PLL_Top/schematic, simulator spectre
  Models: /home/ff/eecs251b/sky130/sky130_cds/sky130_release_0.0.1/libs/sky130_fd_pr_main/../../models/sky130.lib.spice[tt], /home/ff/eecs251b/sky130/sky130_conv.spice
  Variables: t_delay = 0; t_rise = 1p; f_clk = 50MHz
  Temperature: 27
  Analysis tran: stop=64/VAR("f_clk") errpreset=moderate
  Output VT("/Vout")
  Output VT("/CLK_FB")
  Output VT("/CLK_IN")
  Signals: /Vout, /CLK_FB, /CLK_IN
Run mode: Single Run, Sweeps and Corners
