ADE simulation setup
Test EECS251B_project_CP_PLL_clk_divider_tb_1: EECS251B_project_CP_PLL/clk_divider_tb/schematic, simulator spectre
  Models: /home/ff/eecs251b/sky130/sky130_cds/sky130_release_0.0.1/libs/sky130_fd_pr_main/../../models/sky130.lib.spice[tt], /home/ff/eecs251b/sky130/sky130_conv.spice
  Variables: f_clk = 1.6G; t_delay = 1n; t_rise = 1p
  Temperature: 27
  Analysis tran: stop=50n errpreset=moderate
  Output Vout = VT("/Vout")
  Output VT("/Vin")
  Output v("/Vin" ?result "pss_fd") (unticked)
  Output v("/Vout" ?result "pss_fd") (unticked)
  Signals: /Vout
Run mode: Single Run, Sweeps and Corners
