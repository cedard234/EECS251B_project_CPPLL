ADE simulation setup
Run mode: Single Run, Sweeps and Corners
Tests:
  EECS251B_project_CP_PLL_clk_divider_tb_1: EECS251B_project_CP_PLL/clk_divider_tb/schematic, simulator spectre
    Variables: f_clk = 1.6G; t_delay = 1n; t_rise = 1p
    Outputs: Vout; VT("/Vin"); v("/Vin" ?result "pss_fd"); v("/Vout" ?result "pss_fd")
