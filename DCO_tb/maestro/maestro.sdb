ADE simulation setup
Run mode: Single Run, Sweeps and Corners
Tests:
  EECS251B_project_CP_PLL_DCO_tb_1: EECS251B_project_CP_PLL/DCO_tb/schematic, simulator spectre
    Variables: Vcond = {From/To}Auto:0:32:1{From/To}
    Outputs: VT(")) "); Vout_tran; Vint_tran; Vout_pss_fd; harmonic(xval(getData("/Vout+" ?result "pss_fd")) '1); Freq
