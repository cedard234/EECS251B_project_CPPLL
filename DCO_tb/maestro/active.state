ADE simulation setup
Test EECS251B_project_CP_PLL_DCO_tb_1: EECS251B_project_CP_PLL/DCO_tb/schematic, simulator spectre
  Models: /home/ff/eecs251b/sky130/sky130_cds/sky130_release_0.0.1/libs/sky130_fd_pr_main/../../models/sky130.lib.spice[tt]
  Variables: Vcond = 0.0
  Temperature: 27
  Initial conditions: /I0/Vint = 1.8; /I0/net4 = 0
  Analysis pss: engine=Shooting fund=1.6G harms=1 oscana=t p=/Vout n=/gnd! errpreset=conservative
  Analysis dc: (saves the operating point)
  Analysis tran: stop=10n errpreset=liberal
  Output Vout_tran = VT("/Vout") (unticked)
  Output Vint_tran = VT("/I0/Vint") (unticked)
  Output Vout_pss_fd = v("/Vout" ?result "pss_fd") (unticked)
  Output Freq = harmonic(xval(getData("/Vout" ?result "pss_fd")) '1)
  Signals: /Vout, /I0/Vint
Run mode: Single Run, Sweeps and Corners
Setup values for test EECS251B_project_CP_PLL_DCO_tb_1: Vcond = {From/To}Auto:0:32:1{From/To}
